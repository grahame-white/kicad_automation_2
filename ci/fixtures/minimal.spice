* Minimal resistor divider
V1 in 0 DC 5V
R1 in mid 1k
R2 mid 0 1k
.dc V1 5 5 1
.print dc V(mid)
.end
